* SPICE Model : Release=Helvellyn_V2.1.0.beta.2.hotfix.3 Simulator=spectre

simulator lang=spectre

library nch_modified

section typ
parameters dvfbo=-0.237
parameters duo=0.0153637

#parameters dvfbo=-0.0227012
#parameters duo=0.0120637

include "nch_modified.scs" section=mos
endsection typ

section fast
parameters dvfbo=-0.0697012
parameters duo=0.0137637

include "nch_modified.scs" section=mos
endsection fast

section slow
parameters dvfbo=0.0225
parameters duo=0.0103007

include "nch_modified.scs" section=mos
endsection slow

section mos

inline subckt nch_modified (d g s)
parameters
+ l = 1u
+ w = 1u

nch_modified_i (d g s g) nch_modified w=w l=l

//****************************************** nfet ******************************************

# cico     = 9.22695
# cicfo    = 1.94938
# pscel    = 0.1
# pscelexp = 2
# pscebo   = 1
# cto      = 0.241545

model nch_modified utsoi2
+type     = n
+level    = 76             version  = 2.2
+swclipchk = 1
+swgidl   = 1              swign    = 0
+swscale  = 1              tr       = 25             qmc      = 0
+lvaro    = 0              lvarl    = 0              lvarw    = 0
+lap      = 0              wvaro    = 0              wvarl    = 0
+wvarw    = 0              wot      = 0              dlq      = 0
+dwq      = 0              toxeo    = 1.1745e-08     tsio     = 2e-08
+xgeo     = 0              tboxo    = 1e-06          ncho     = 0
+nsubo    = 1e+21          cto      = 1.241545       toxpo    = 2.5e-08
+novo     = 1e+21          novdo    = 1e+20          vfbo     = dvfbo
+vfbl     = -0.0467954     vfblexp  = 2              vfbl2    = 0
+vfblexp2 = 2              vfbw     = 0.0866633      vfblw    = 0
+vfbbo    = 0              vfblbo   = 0              stvfbo   = 0
+stvfbl   = 0              stvfbw   = 0              stvfblw  = 0
+cicfo    = 1.94938        cico     = 9.22695        pscel    = 0.1
+pscelexp = 2              pscew    = 0              pscebo   = 1
+nsddco   = 1e+22          pscedlbo = 0              pncew    = 0
+cfl      = 0              cflexp   = 2              cfw      = 0
+cfbo     = 1              stcfl    = 0              cfdo     = 0.2
+cfdll    = 0              cfdlw    = 0              cfdlbo   = 0
+uo       = duo            fbet1    = -0.865524      fbet1w   = 0
+lp1      = 1e-08          lp1w     = 0              fbet2    = 0
+lp2      = 1e-08          betw1    = 0.305085       betw2    = 0
+wbet     = 1e-08          betnbo   = 0.1            stbeto   = 1.5
+stbetl   = 0              stbetw   = 0              stbetlw  = 0
+cso      = 7.58482        csl      = 1.61515        cslexp   = 1
+csw      = 0              cslw     = 0              csfio    = 0.254872
+csbio    = 0              stcso    = 0              stcsl    = 0
+stcsw    = 0              stcslw   = 0              thecso   = 0.120043
+stthecso = 0              csthro   = 2              csthrbo  = 1
+mueo     = 0.23507        stmueo   = 0              themuo   = 17.7897
+stthemuo = 0              xcoro    = 0.115102       xcorl    = 0.0357465
+xcorlexp = 1              xcorw    = 0              xcorlw   = 0
+xcorbo   = 1              stxcoro  = 0              fetao    = 1
+rsw1     = 30             rsw2     = 0              rsigo    = 0
+strso    = 0              rsgo     = 0              thersgo  = 2
+rsbo     = 0              thesato  = 116.949        thesatl  = -100
+thesatlexp = 1.99996
+thesatw  = 1              thesatlw = 0
+stthesato = -0.1
+stthesatl = 0
+stthesatw = 0
+stthesatlw = 0
+thesatgo = 0              thesatbo = 0              axo      = 7.06782
+axl      = 0.020955       axlexp   = 7.40117        axl2     = 0
+axlexp2  = 1.5            alpl1    = 0.077169       alplexp  = 5.92213
+alpl2    = 0.490639       alplexp2 = 7.26746        alpw     = -0.263837
+alp1l1   = 0.1994         alp1lexp = 5              alp1l2   = 1.4769
+alp1lexp2 = 6.90995
+alp1w    = 0              alpbo    = 0              vpo      = 0.05
+vpgo     = 0              gcoo     = 0              iginvlw  = 0
+igovinvw = 0
+igovinvdw = 0
+igovaccw = 0
+igovaccdw = 0
+stigo    = 0              gc2cho   = 0.375          gc3cho   = 0.063
+gc2ovinvo = 0.375
+gc3ovinvo = 0.063
+gc2ovacco = 0.375
+gc3ovacco = 0.063
+gcdovl   = 0              gcvdovo  = 1              chibo    = 3.1
+niginvo  = 0
+
+
+agidl    = 1              agidld   = 0
+agidlw   = 0              agidldw  = 0              bgidlo   = 41
+bgidldo  = 41             stbgidlo = 0
+stbgidldo = 0
+cgidlo   = 0              cgidldo  = 0
+
+
+cgbovo   = 0              cgbovl   = 0.465378
+nsdaco   = 1e+22          fifw     = 0              fsceaco  = 0
+lovo     = 2.76494e-07    lovdo    = 0              covdlo   = 0
+covdlw   = 0              covdlbo  = 0              dvfbovo  = 0
+cfro     = 0              cfrdo    = 0              cfrw     = 0
+cfrdw    = 0              csdo     = 1              csdbpo   = 0
+rtho     = 100000         rthl     = 1.5            rthw     = 3
+rthlw    = 4.5            strtho   = 0              ctho     = 1e-12
+lambtho  = 1e-07          ftho     = 0              fnto     = 1
+fntexcl  = 0
+fntexclexp = 2
+nfalw    = 8e+22          nfblw    = 3e+07
+nfclw    = 0              nfeo     = 0              nfebo    = 0
+efo      = 1              swstress = 1              saref    = 1e-06
+sbref    = 1e-06          wlod     = 0              kuo      = 0
+kvsat    = 0              tkuo     = 0              lkuo     = 0
+wkuo     = 0              pkuo     = 0              llodkuo  = 0
+wlodkuo  = 0              kvtho    = 0              lkvtho   = 0
+wkvtho   = 0              pkvtho   = 0              llodvth  = 0
+wlodvth  = 0              stetao   = 0              lodetao  = 1
+strlambda = 1e-07
+stralpha = 3              strdvfbo = 0
+strwdvfbo = 0
+strdcfl  = 0              strruo   = 0              strtruo  = 0
+strrvsat = 0

ends nch_modified

endsection mos
endlibrary nch_modified
