simulator lang=spectre

section 10um
parameters tigzo=30.0e-9
parameters vthcalc=0.53-0.01*tigzo*1.0e9

model nch_bsimsoi bsimsoi type=n
+ soimod=0
+ tox=15.0e-9
+ tsi=tigzo
+ tbox=3e-3
+ epsrox=8.6
+ eot=4.53e-10
+ epsrsub=10
+ epsrgate=10
+ nsub=6e16
+ nch=1.7e17
+ nsd=1.0e20
+ vtho=vthcalc
+ voff=-0.15
+ nfactor=0.01
+ cit=3e-6
+ eta0=0.08
+ u0=22
+ ua=0
+ ub=0
+ vsat=3e5
+ a0=1
+ a1=0
+ ags=0
+ pbswg=0.7
+ pclm=1.3
+ rdsmod=0
+ rdsw=100
+ rd=0
+ rs=0
+ shmod=0
