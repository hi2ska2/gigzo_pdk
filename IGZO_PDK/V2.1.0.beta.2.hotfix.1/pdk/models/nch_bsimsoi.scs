simulator lang=spectre

model nch_bsimsoi bsimsoi type=n
+ soimod=2
+ tox=5.0e-8
+ tsi=10.0e-8
+ tbox=1e-8
+ nsub=1e16
+ nch=1.7e17
+ nsd=1e20
+ vth0=0.01
+ voff=-0.15
+ nfactor=0.4
+ eta0=0.08
+ u0=90
+ vsat=8e4
+ a0=1
+ a1=0
+ ags=0
+ pbswg=0.7
+ rdsmod=1
+ rd=0
+ rs=0
+ rdsw=100
+ pclm=1.3
+ shmod=0
